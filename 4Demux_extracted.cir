* Extracted by KLayout with SKY130 LVS runset on : 15/10/2026 11:12

* cell 4Demux
.SUBCKT 4Demux
* cell instance $1 r0 *1 1.77,10.59
X$1 \$9 \$1 \$4 sky130_gnd \$I25 NOT
* cell instance $2 r0 *1 3.41,13.25
X$2 \$1 vias_gen$11
* cell instance $3 r0 *1 6.39,13.29
X$3 \$1 vias_gen$10
* cell instance $4 r0 *1 6.31,24.43
X$4 \$1 vias_gen$10
* cell instance $5 r0 *1 6.31,18.83
X$5 \$1 vias_gen$10
* cell instance $6 r0 *1 5.48,20.92
X$6 \$2 \$4 \$1 \$4 sky130_gnd \$I2 NAND
* cell instance $7 r0 *1 18.02,24.35
X$7 \$1 vias_gen$13
* cell instance $8 r0 *1 18.02,18.8
X$8 \$1 vias_gen$13
* cell instance $9 m0 *1 5.48,21.67
X$9 \$10 \$4 \$1 \$4 sky130_gnd \$I32 \$I2 NAND$1
* cell instance $10 r0 *1 13.63,13.31
X$10 \$2 vias_gen$11
* cell instance $11 r0 *1 5.48,10.59
X$11 \$2 \$4 \$9 \$4 sky130_gnd \$I34 \$I32 NAND$1$1
* cell instance $12 r0 *1 8.26,23.56
X$12 \$2 vias_gen$10
* cell instance $13 r0 *1 8.26,13.29
X$13 \$2 vias_gen$10
* cell instance $14 r0 *1 4.19,23.63
X$14 \$2 vias_gen$10
* cell instance $15 r0 *1 4.19,18.85
X$15 \$2 vias_gen$10
* cell instance $16 r0 *1 3.42,18.8
X$16 \$2 vias_gen$13
* cell instance $17 m0 *1 1.77,21.67
X$17 \$10 \$2 \$4 sky130_gnd \$I25 NOT$1
* cell instance $18 r0 *1 13.67,23.63
X$18 \$2 vias_gen$13
* cell instance $19 m0 *1 5.48,11.34
X$19 \$10 \$4 \$9 \$4 sky130_gnd \$I34 NAND$1$1$1
* cell instance $20 r0 *1 11.26,26.35
X$20 \$4 vias_gen$10
* cell instance $21 r0 *1 11.26,5.59
X$21 \$4 vias_gen$10
* cell instance $22 r0 *1 11.26,15.92
X$22 \$4 vias_gen$10
* cell instance $23 r0 *1 18.15,14.18
X$23 \$9 vias_gen$11
* cell instance $24 r0 *1 18.15,8.28
X$24 \$9 vias_gen$11
* cell instance $25 r0 *1 3.28,14.14
X$25 \$9 vias_gen$10
* cell instance $26 r0 *1 3.28,8.31
X$26 \$9 vias_gen$10
* cell instance $27 r0 *1 13.67,7.49
X$27 \$10 vias_gen$11
* cell instance $28 r0 *1 13.67,17.95
X$28 \$10 vias_gen$11
* cell instance $29 r0 *1 5.27,7.44
X$29 \$10 vias_gen$10
* cell instance $30 r0 *1 5.27,19.82
X$30 \$10 vias_gen$10
* cell instance $31 r0 *1 5.27,18.02
X$31 \$10 vias_gen$10
* cell instance $32 r0 *1 12.52,21.16
X$32 sky130_gnd vias_gen$10
* cell instance $33 r0 *1 12.52,10.83
X$33 sky130_gnd vias_gen$10
.ENDS 4Demux

* cell vias_gen$13
* pin
.SUBCKT vias_gen$13 \$1
.ENDS vias_gen$13

* cell vias_gen$10
* pin
.SUBCKT vias_gen$10 \$1
.ENDS vias_gen$10

* cell vias_gen$11
* pin
.SUBCKT vias_gen$11 \$1
.ENDS vias_gen$11

* cell NAND$1$1$1
* pin
* pin
* pin
* pin
* pin sky130_gnd
* pin
.SUBCKT NAND$1$1$1 \$2 \$3 \$4 \$5 sky130_gnd \$I95
* cell instance $1 r0 *1 4.475,1.88
X$1 \$1 vias_gen$4$2$1$1
* cell instance $2 r0 *1 4.2,1.28
X$2 \$6 \$6 \$1 \$3 \$3 nfet$3$1$1
* cell instance $3 r0 *1 11.905,3.73
X$3 \$5 \$5 \$1 \$5 \$1 \$4 \$4 \$4 \$4 \$5 pfet$2$1$1
* cell instance $4 r0 *1 6.105,3.73
X$4 \$5 \$5 \$1 \$5 \$1 \$2 \$2 \$2 \$2 \$5 pfet$2$1$1
* cell instance $5 r0 *1 0.305,3.73
X$5 \$5 \$5 \$1 \$5 \$1 \$3 \$3 \$3 \$3 \$5 pfet$2$1$1
* cell instance $6 r0 *1 1.695,4.4
X$6 \$1 vias_gen$2$1$1$1
* cell instance $7 r0 *1 5.6,1.84
X$7 \$1 vias_gen$2$1$1$1
* cell instance $8 r0 *1 4.695,4.4
X$8 \$1 vias_gen$2$1$1$1
* cell instance $9 r0 *1 4.485,4.37
X$9 \$1 vias_gen$4$2$1$1
* cell instance $10 r0 *1 7.495,4.4
X$10 \$1 vias_gen$2$1$1$1
* cell instance $11 r0 *1 10.495,4.4
X$11 \$1 vias_gen$2$1$1$1
* cell instance $12 r0 *1 13.285,4.4
X$12 \$1 vias_gen$2$1$1$1
* cell instance $13 r0 *1 16.285,4.4
X$13 \$1 vias_gen$2$1$1$1
* cell instance $14 r0 *1 7,1.28
X$14 \$6 \$6 \$8 \$2 \$2 nfet$3$1$1
* cell instance $15 r0 *1 11.1,1.28
X$15 sky130_gnd sky130_gnd \$8 \$4 \$4 nfet$3$1$1
* cell instance $16 r0 *1 0.18,5.29
X$16 \$5 vias_gen$8$1$1
* cell instance $17 r0 *1 9.8,1.28
X$17 \$6 sky130_gnd sky130_gnd nfet$1$1$1$1
* cell instance $18 r0 *1 4.195,1.06
X$18 \$6 vias_gen$2$1$1$1
* cell instance $19 r0 *1 6.985,1.06
X$19 \$6 vias_gen$2$1$1$1
* cell instance $20 r0 *1 9.79,1.06
X$20 \$6 vias_gen$2$1$1$1
* cell instance $21 r0 *1 8.39,1.84
X$21 \$8 vias_gen$2$1$1$1
* cell instance $22 r0 *1 12.48,1.84
X$22 \$8 vias_gen$2$1$1$1
* cell instance $23 r0 *1 4.205,0.125
X$23 \$I95 sky130_gnd vias_gen$1$1$1$1
* device instance $1 r0 *1 1.105,4.23 sky130_fd_pr__pfet_01v8_lvt
XM$1 \$5 \$3 \$1 \$5 sky130_fd_pr__pfet_01v8_lvt L=1000000 W=1000000
+ AS=300000000000 AD=250000000000 PS=2600000 PD=1500000
* device instance $2 r0 *1 2.605,4.23 sky130_fd_pr__pfet_01v8_lvt
XM$2 \$1 \$3 \$5 \$5 sky130_fd_pr__pfet_01v8_lvt L=1000000 W=1000000
+ AS=250000000000 AD=250000000000 PS=1500000 PD=1500000
* device instance $3 r0 *1 4.105,4.23 sky130_fd_pr__pfet_01v8_lvt
XM$3 \$5 \$3 \$1 \$5 sky130_fd_pr__pfet_01v8_lvt L=1000000 W=1000000
+ AS=250000000000 AD=250000000000 PS=1500000 PD=1500000
* device instance $4 r0 *1 5.605,4.23 sky130_fd_pr__pfet_01v8_lvt
XM$4 \$1 \$3 \$5 \$5 sky130_fd_pr__pfet_01v8_lvt L=1000000 W=1000000
+ AS=250000000000 AD=150000000000 PS=1500000 PD=1300000
* device instance $5 r0 *1 6.905,4.23 sky130_fd_pr__pfet_01v8_lvt
XM$5 \$5 \$2 \$1 \$5 sky130_fd_pr__pfet_01v8_lvt L=1000000 W=1000000
+ AS=150000000000 AD=250000000000 PS=1300000 PD=1500000
* device instance $6 r0 *1 8.405,4.23 sky130_fd_pr__pfet_01v8_lvt
XM$6 \$1 \$2 \$5 \$5 sky130_fd_pr__pfet_01v8_lvt L=1000000 W=1000000
+ AS=250000000000 AD=250000000000 PS=1500000 PD=1500000
* device instance $7 r0 *1 9.905,4.23 sky130_fd_pr__pfet_01v8_lvt
XM$7 \$5 \$2 \$1 \$5 sky130_fd_pr__pfet_01v8_lvt L=1000000 W=1000000
+ AS=250000000000 AD=250000000000 PS=1500000 PD=1500000
* device instance $8 r0 *1 11.405,4.23 sky130_fd_pr__pfet_01v8_lvt
XM$8 \$1 \$2 \$5 \$5 sky130_fd_pr__pfet_01v8_lvt L=1000000 W=1000000
+ AS=250000000000 AD=150000000000 PS=1500000 PD=1300000
* device instance $9 r0 *1 12.705,4.23 sky130_fd_pr__pfet_01v8_lvt
XM$9 \$5 \$4 \$1 \$5 sky130_fd_pr__pfet_01v8_lvt L=1000000 W=1000000
+ AS=150000000000 AD=250000000000 PS=1300000 PD=1500000
* device instance $10 r0 *1 14.205,4.23 sky130_fd_pr__pfet_01v8_lvt
XM$10 \$1 \$4 \$5 \$5 sky130_fd_pr__pfet_01v8_lvt L=1000000 W=1000000
+ AS=250000000000 AD=250000000000 PS=1500000 PD=1500000
* device instance $11 r0 *1 15.705,4.23 sky130_fd_pr__pfet_01v8_lvt
XM$11 \$5 \$4 \$1 \$5 sky130_fd_pr__pfet_01v8_lvt L=1000000 W=1000000
+ AS=250000000000 AD=250000000000 PS=1500000 PD=1500000
* device instance $12 r0 *1 17.205,4.23 sky130_fd_pr__pfet_01v8_lvt
XM$12 \$1 \$4 \$5 \$5 sky130_fd_pr__pfet_01v8_lvt L=1000000 W=1000000
+ AS=250000000000 AD=300000000000 PS=1500000 PD=2600000
* device instance $13 r0 *1 5,1.78 sky130_fd_pr__nfet_01v8_lvt
XM$13 \$6 \$3 \$1 sky130_gnd sky130_fd_pr__nfet_01v8_lvt L=1000000 W=1000000
+ AS=300000000000 AD=250000000000 PS=2600000 PD=1500000
* device instance $14 r0 *1 6.5,1.78 sky130_fd_pr__nfet_01v8_lvt
XM$14 \$1 \$3 \$6 sky130_gnd sky130_fd_pr__nfet_01v8_lvt L=1000000 W=1000000
+ AS=250000000000 AD=150000000000 PS=1500000 PD=1300000
* device instance $15 r0 *1 7.8,1.78 sky130_fd_pr__nfet_01v8_lvt
XM$15 \$6 \$2 \$8 sky130_gnd sky130_fd_pr__nfet_01v8_lvt L=1000000 W=1000000
+ AS=150000000000 AD=250000000000 PS=1300000 PD=1500000
* device instance $16 r0 *1 9.3,1.78 sky130_fd_pr__nfet_01v8_lvt
XM$16 \$8 \$2 \$6 sky130_gnd sky130_fd_pr__nfet_01v8_lvt L=1000000 W=1000000
+ AS=250000000000 AD=150000000000 PS=1500000 PD=1300000
* device instance $17 r0 *1 10.6,1.78 sky130_fd_pr__nfet_01v8_lvt
XM$17 \$6 sky130_gnd sky130_gnd sky130_gnd sky130_fd_pr__nfet_01v8_lvt
+ L=1000000 W=1000000 AS=150000000000 AD=150000000000 PS=1300000 PD=1300000
* device instance $18 r0 *1 11.9,1.78 sky130_fd_pr__nfet_01v8_lvt
XM$18 sky130_gnd \$4 \$8 sky130_gnd sky130_fd_pr__nfet_01v8_lvt L=1000000
+ W=1000000 AS=150000000000 AD=250000000000 PS=1300000 PD=1500000
* device instance $19 r0 *1 13.4,1.78 sky130_fd_pr__nfet_01v8_lvt
XM$19 \$8 \$4 sky130_gnd sky130_gnd sky130_fd_pr__nfet_01v8_lvt L=1000000
+ W=1000000 AS=250000000000 AD=300000000000 PS=1500000 PD=2600000
.ENDS NAND$1$1$1

* cell NAND$1$1
* pin
* pin
* pin
* pin
* pin sky130_gnd
* pin
* pin
.SUBCKT NAND$1$1 \$2 \$3 \$4 \$5 sky130_gnd \$I117 \$I116
* cell instance $1 r0 *1 4.475,1.88
X$1 \$1 vias_gen$4$2$1
* cell instance $2 r0 *1 4.2,1.28
X$2 \$6 \$6 \$1 \$3 \$3 nfet$3$1
* cell instance $3 r0 *1 11.905,3.73
X$3 \$5 \$5 \$1 \$5 \$1 \$4 \$4 \$4 \$4 \$5 pfet$2$1
* cell instance $4 r0 *1 6.105,3.73
X$4 \$5 \$5 \$1 \$5 \$1 \$2 \$2 \$2 \$2 \$5 pfet$2$1
* cell instance $5 r0 *1 0.305,3.73
X$5 \$5 \$5 \$1 \$5 \$1 \$3 \$3 \$3 \$3 \$5 pfet$2$1
* cell instance $6 r0 *1 1.695,4.4
X$6 \$1 vias_gen$2$1$1
* cell instance $7 r0 *1 5.6,1.84
X$7 \$1 vias_gen$2$1$1
* cell instance $8 r0 *1 4.695,4.4
X$8 \$1 vias_gen$2$1$1
* cell instance $9 r0 *1 4.485,4.37
X$9 \$1 vias_gen$4$2$1
* cell instance $10 r0 *1 7.495,4.4
X$10 \$1 vias_gen$2$1$1
* cell instance $11 r0 *1 10.495,4.4
X$11 \$1 vias_gen$2$1$1
* cell instance $12 r0 *1 13.285,4.4
X$12 \$1 vias_gen$2$1$1
* cell instance $13 r0 *1 16.285,4.4
X$13 \$1 vias_gen$2$1$1
* cell instance $14 r0 *1 7,1.28
X$14 \$6 \$6 \$8 \$2 \$2 nfet$3$1
* cell instance $15 r0 *1 11.1,1.28
X$15 sky130_gnd sky130_gnd \$8 \$4 \$4 nfet$3$1
* cell instance $16 r0 *1 0.18,5.29
X$16 \$5 \$I116 vias_gen$8$1
* cell instance $17 r0 *1 9.8,1.28
X$17 \$6 sky130_gnd sky130_gnd nfet$1$1$1
* cell instance $18 r0 *1 4.195,1.06
X$18 \$6 vias_gen$2$1$1
* cell instance $19 r0 *1 6.985,1.06
X$19 \$6 vias_gen$2$1$1
* cell instance $20 r0 *1 9.79,1.06
X$20 \$6 vias_gen$2$1$1
* cell instance $21 r0 *1 8.39,1.84
X$21 \$8 vias_gen$2$1$1
* cell instance $22 r0 *1 12.48,1.84
X$22 \$8 vias_gen$2$1$1
* cell instance $23 r0 *1 4.205,0.125
X$23 \$I117 sky130_gnd vias_gen$1$1$1
* device instance $1 r0 *1 1.105,4.23 sky130_fd_pr__pfet_01v8_lvt
XM$1 \$5 \$3 \$1 \$5 sky130_fd_pr__pfet_01v8_lvt L=1000000 W=1000000
+ AS=300000000000 AD=250000000000 PS=2600000 PD=1500000
* device instance $2 r0 *1 2.605,4.23 sky130_fd_pr__pfet_01v8_lvt
XM$2 \$1 \$3 \$5 \$5 sky130_fd_pr__pfet_01v8_lvt L=1000000 W=1000000
+ AS=250000000000 AD=250000000000 PS=1500000 PD=1500000
* device instance $3 r0 *1 4.105,4.23 sky130_fd_pr__pfet_01v8_lvt
XM$3 \$5 \$3 \$1 \$5 sky130_fd_pr__pfet_01v8_lvt L=1000000 W=1000000
+ AS=250000000000 AD=250000000000 PS=1500000 PD=1500000
* device instance $4 r0 *1 5.605,4.23 sky130_fd_pr__pfet_01v8_lvt
XM$4 \$1 \$3 \$5 \$5 sky130_fd_pr__pfet_01v8_lvt L=1000000 W=1000000
+ AS=250000000000 AD=150000000000 PS=1500000 PD=1300000
* device instance $5 r0 *1 6.905,4.23 sky130_fd_pr__pfet_01v8_lvt
XM$5 \$5 \$2 \$1 \$5 sky130_fd_pr__pfet_01v8_lvt L=1000000 W=1000000
+ AS=150000000000 AD=250000000000 PS=1300000 PD=1500000
* device instance $6 r0 *1 8.405,4.23 sky130_fd_pr__pfet_01v8_lvt
XM$6 \$1 \$2 \$5 \$5 sky130_fd_pr__pfet_01v8_lvt L=1000000 W=1000000
+ AS=250000000000 AD=250000000000 PS=1500000 PD=1500000
* device instance $7 r0 *1 9.905,4.23 sky130_fd_pr__pfet_01v8_lvt
XM$7 \$5 \$2 \$1 \$5 sky130_fd_pr__pfet_01v8_lvt L=1000000 W=1000000
+ AS=250000000000 AD=250000000000 PS=1500000 PD=1500000
* device instance $8 r0 *1 11.405,4.23 sky130_fd_pr__pfet_01v8_lvt
XM$8 \$1 \$2 \$5 \$5 sky130_fd_pr__pfet_01v8_lvt L=1000000 W=1000000
+ AS=250000000000 AD=150000000000 PS=1500000 PD=1300000
* device instance $9 r0 *1 12.705,4.23 sky130_fd_pr__pfet_01v8_lvt
XM$9 \$5 \$4 \$1 \$5 sky130_fd_pr__pfet_01v8_lvt L=1000000 W=1000000
+ AS=150000000000 AD=250000000000 PS=1300000 PD=1500000
* device instance $10 r0 *1 14.205,4.23 sky130_fd_pr__pfet_01v8_lvt
XM$10 \$1 \$4 \$5 \$5 sky130_fd_pr__pfet_01v8_lvt L=1000000 W=1000000
+ AS=250000000000 AD=250000000000 PS=1500000 PD=1500000
* device instance $11 r0 *1 15.705,4.23 sky130_fd_pr__pfet_01v8_lvt
XM$11 \$5 \$4 \$1 \$5 sky130_fd_pr__pfet_01v8_lvt L=1000000 W=1000000
+ AS=250000000000 AD=250000000000 PS=1500000 PD=1500000
* device instance $12 r0 *1 17.205,4.23 sky130_fd_pr__pfet_01v8_lvt
XM$12 \$1 \$4 \$5 \$5 sky130_fd_pr__pfet_01v8_lvt L=1000000 W=1000000
+ AS=250000000000 AD=300000000000 PS=1500000 PD=2600000
* device instance $13 r0 *1 5,1.78 sky130_fd_pr__nfet_01v8_lvt
XM$13 \$6 \$3 \$1 sky130_gnd sky130_fd_pr__nfet_01v8_lvt L=1000000 W=1000000
+ AS=300000000000 AD=250000000000 PS=2600000 PD=1500000
* device instance $14 r0 *1 6.5,1.78 sky130_fd_pr__nfet_01v8_lvt
XM$14 \$1 \$3 \$6 sky130_gnd sky130_fd_pr__nfet_01v8_lvt L=1000000 W=1000000
+ AS=250000000000 AD=150000000000 PS=1500000 PD=1300000
* device instance $15 r0 *1 7.8,1.78 sky130_fd_pr__nfet_01v8_lvt
XM$15 \$6 \$2 \$8 sky130_gnd sky130_fd_pr__nfet_01v8_lvt L=1000000 W=1000000
+ AS=150000000000 AD=250000000000 PS=1300000 PD=1500000
* device instance $16 r0 *1 9.3,1.78 sky130_fd_pr__nfet_01v8_lvt
XM$16 \$8 \$2 \$6 sky130_gnd sky130_fd_pr__nfet_01v8_lvt L=1000000 W=1000000
+ AS=250000000000 AD=150000000000 PS=1500000 PD=1300000
* device instance $17 r0 *1 10.6,1.78 sky130_fd_pr__nfet_01v8_lvt
XM$17 \$6 sky130_gnd sky130_gnd sky130_gnd sky130_fd_pr__nfet_01v8_lvt
+ L=1000000 W=1000000 AS=150000000000 AD=150000000000 PS=1300000 PD=1300000
* device instance $18 r0 *1 11.9,1.78 sky130_fd_pr__nfet_01v8_lvt
XM$18 sky130_gnd \$4 \$8 sky130_gnd sky130_fd_pr__nfet_01v8_lvt L=1000000
+ W=1000000 AS=150000000000 AD=250000000000 PS=1300000 PD=1500000
* device instance $19 r0 *1 13.4,1.78 sky130_fd_pr__nfet_01v8_lvt
XM$19 \$8 \$4 sky130_gnd sky130_gnd sky130_fd_pr__nfet_01v8_lvt L=1000000
+ W=1000000 AS=250000000000 AD=300000000000 PS=1500000 PD=2600000
.ENDS NAND$1$1

* cell NOT$1
* pin
* pin
* pin
* pin sky130_gnd
* pin
.SUBCKT NOT$1 \$1 \$2 \$8 sky130_gnd \$I5
* cell instance $1 r0 *1 1.53,1.55
X$1 \$1 vias_gen$6$1
* cell instance $2 r0 *1 1.045,1.28
X$2 sky130_gnd \$1 \$2 sky130_gnd nfet$2$1
* cell instance $3 r0 *1 2.32,1.61
X$3 \$1 vias_gen$4$1$1
* cell instance $4 r0 *1 1.695,4.34
X$4 \$1 vias_gen$4$1$1
* cell instance $5 r0 *1 0.305,3.73
X$5 \$8 \$8 \$1 \$2 \$2 \$8 pfet$1$1
* cell instance $6 r0 *1 1.53,4.3
X$6 \$1 vias_gen$6$1
* cell instance $7 r0 *1 0.18,5.29
X$7 \$8 \$I5 vias_gen$5$1
* cell instance $8 r0 *1 1.045,0.125
X$8 sky130_gnd vias_gen$7$1
.ENDS NOT$1

* cell NAND$1
* pin
* pin
* pin
* pin
* pin sky130_gnd
* pin
* pin
.SUBCKT NAND$1 \$2 \$3 \$4 \$5 sky130_gnd \$I117 \$I116
* cell instance $1 r0 *1 4.475,1.88
X$1 \$1 vias_gen$4$2
* cell instance $2 r0 *1 4.2,1.28
X$2 \$6 \$6 \$1 \$3 \$3 nfet$3
* cell instance $3 r0 *1 11.905,3.73
X$3 \$5 \$5 \$1 \$5 \$1 \$4 \$4 \$4 \$4 \$5 pfet$2
* cell instance $4 r0 *1 6.105,3.73
X$4 \$5 \$5 \$1 \$5 \$1 \$2 \$2 \$2 \$2 \$5 pfet$2
* cell instance $5 r0 *1 0.305,3.73
X$5 \$5 \$5 \$1 \$5 \$1 \$3 \$3 \$3 \$3 \$5 pfet$2
* cell instance $6 r0 *1 1.695,4.4
X$6 \$1 vias_gen$2$1
* cell instance $7 r0 *1 5.6,1.84
X$7 \$1 vias_gen$2$1
* cell instance $8 r0 *1 4.695,4.4
X$8 \$1 vias_gen$2$1
* cell instance $9 r0 *1 4.485,4.37
X$9 \$1 vias_gen$4$2
* cell instance $10 r0 *1 7.495,4.4
X$10 \$1 vias_gen$2$1
* cell instance $11 r0 *1 10.495,4.4
X$11 \$1 vias_gen$2$1
* cell instance $12 r0 *1 13.285,4.4
X$12 \$1 vias_gen$2$1
* cell instance $13 r0 *1 16.285,4.4
X$13 \$1 vias_gen$2$1
* cell instance $14 r0 *1 7,1.28
X$14 \$6 \$6 \$8 \$2 \$2 nfet$3
* cell instance $15 r0 *1 11.1,1.28
X$15 sky130_gnd sky130_gnd \$8 \$4 \$4 nfet$3
* cell instance $16 r0 *1 0.18,5.29
X$16 \$5 \$I117 vias_gen$8
* cell instance $17 r0 *1 9.8,1.28
X$17 \$6 sky130_gnd sky130_gnd nfet$1$1
* cell instance $18 r0 *1 4.195,1.06
X$18 \$6 vias_gen$2$1
* cell instance $19 r0 *1 6.985,1.06
X$19 \$6 vias_gen$2$1
* cell instance $20 r0 *1 9.79,1.06
X$20 \$6 vias_gen$2$1
* cell instance $21 r0 *1 8.39,1.84
X$21 \$8 vias_gen$2$1
* cell instance $22 r0 *1 12.48,1.84
X$22 \$8 vias_gen$2$1
* cell instance $23 r0 *1 4.205,0.125
X$23 \$I116 sky130_gnd vias_gen$1$1
* device instance $1 r0 *1 1.105,4.23 sky130_fd_pr__pfet_01v8_lvt
XM$1 \$5 \$3 \$1 \$5 sky130_fd_pr__pfet_01v8_lvt L=1000000 W=1000000
+ AS=300000000000 AD=250000000000 PS=2600000 PD=1500000
* device instance $2 r0 *1 2.605,4.23 sky130_fd_pr__pfet_01v8_lvt
XM$2 \$1 \$3 \$5 \$5 sky130_fd_pr__pfet_01v8_lvt L=1000000 W=1000000
+ AS=250000000000 AD=250000000000 PS=1500000 PD=1500000
* device instance $3 r0 *1 4.105,4.23 sky130_fd_pr__pfet_01v8_lvt
XM$3 \$5 \$3 \$1 \$5 sky130_fd_pr__pfet_01v8_lvt L=1000000 W=1000000
+ AS=250000000000 AD=250000000000 PS=1500000 PD=1500000
* device instance $4 r0 *1 5.605,4.23 sky130_fd_pr__pfet_01v8_lvt
XM$4 \$1 \$3 \$5 \$5 sky130_fd_pr__pfet_01v8_lvt L=1000000 W=1000000
+ AS=250000000000 AD=150000000000 PS=1500000 PD=1300000
* device instance $5 r0 *1 6.905,4.23 sky130_fd_pr__pfet_01v8_lvt
XM$5 \$5 \$2 \$1 \$5 sky130_fd_pr__pfet_01v8_lvt L=1000000 W=1000000
+ AS=150000000000 AD=250000000000 PS=1300000 PD=1500000
* device instance $6 r0 *1 8.405,4.23 sky130_fd_pr__pfet_01v8_lvt
XM$6 \$1 \$2 \$5 \$5 sky130_fd_pr__pfet_01v8_lvt L=1000000 W=1000000
+ AS=250000000000 AD=250000000000 PS=1500000 PD=1500000
* device instance $7 r0 *1 9.905,4.23 sky130_fd_pr__pfet_01v8_lvt
XM$7 \$5 \$2 \$1 \$5 sky130_fd_pr__pfet_01v8_lvt L=1000000 W=1000000
+ AS=250000000000 AD=250000000000 PS=1500000 PD=1500000
* device instance $8 r0 *1 11.405,4.23 sky130_fd_pr__pfet_01v8_lvt
XM$8 \$1 \$2 \$5 \$5 sky130_fd_pr__pfet_01v8_lvt L=1000000 W=1000000
+ AS=250000000000 AD=150000000000 PS=1500000 PD=1300000
* device instance $9 r0 *1 12.705,4.23 sky130_fd_pr__pfet_01v8_lvt
XM$9 \$5 \$4 \$1 \$5 sky130_fd_pr__pfet_01v8_lvt L=1000000 W=1000000
+ AS=150000000000 AD=250000000000 PS=1300000 PD=1500000
* device instance $10 r0 *1 14.205,4.23 sky130_fd_pr__pfet_01v8_lvt
XM$10 \$1 \$4 \$5 \$5 sky130_fd_pr__pfet_01v8_lvt L=1000000 W=1000000
+ AS=250000000000 AD=250000000000 PS=1500000 PD=1500000
* device instance $11 r0 *1 15.705,4.23 sky130_fd_pr__pfet_01v8_lvt
XM$11 \$5 \$4 \$1 \$5 sky130_fd_pr__pfet_01v8_lvt L=1000000 W=1000000
+ AS=250000000000 AD=250000000000 PS=1500000 PD=1500000
* device instance $12 r0 *1 17.205,4.23 sky130_fd_pr__pfet_01v8_lvt
XM$12 \$1 \$4 \$5 \$5 sky130_fd_pr__pfet_01v8_lvt L=1000000 W=1000000
+ AS=250000000000 AD=300000000000 PS=1500000 PD=2600000
* device instance $13 r0 *1 5,1.78 sky130_fd_pr__nfet_01v8_lvt
XM$13 \$6 \$3 \$1 sky130_gnd sky130_fd_pr__nfet_01v8_lvt L=1000000 W=1000000
+ AS=300000000000 AD=250000000000 PS=2600000 PD=1500000
* device instance $14 r0 *1 6.5,1.78 sky130_fd_pr__nfet_01v8_lvt
XM$14 \$1 \$3 \$6 sky130_gnd sky130_fd_pr__nfet_01v8_lvt L=1000000 W=1000000
+ AS=250000000000 AD=150000000000 PS=1500000 PD=1300000
* device instance $15 r0 *1 7.8,1.78 sky130_fd_pr__nfet_01v8_lvt
XM$15 \$6 \$2 \$8 sky130_gnd sky130_fd_pr__nfet_01v8_lvt L=1000000 W=1000000
+ AS=150000000000 AD=250000000000 PS=1300000 PD=1500000
* device instance $16 r0 *1 9.3,1.78 sky130_fd_pr__nfet_01v8_lvt
XM$16 \$8 \$2 \$6 sky130_gnd sky130_fd_pr__nfet_01v8_lvt L=1000000 W=1000000
+ AS=250000000000 AD=150000000000 PS=1500000 PD=1300000
* device instance $17 r0 *1 10.6,1.78 sky130_fd_pr__nfet_01v8_lvt
XM$17 \$6 sky130_gnd sky130_gnd sky130_gnd sky130_fd_pr__nfet_01v8_lvt
+ L=1000000 W=1000000 AS=150000000000 AD=150000000000 PS=1300000 PD=1300000
* device instance $18 r0 *1 11.9,1.78 sky130_fd_pr__nfet_01v8_lvt
XM$18 sky130_gnd \$4 \$8 sky130_gnd sky130_fd_pr__nfet_01v8_lvt L=1000000
+ W=1000000 AS=150000000000 AD=250000000000 PS=1300000 PD=1500000
* device instance $19 r0 *1 13.4,1.78 sky130_fd_pr__nfet_01v8_lvt
XM$19 \$8 \$4 sky130_gnd sky130_gnd sky130_fd_pr__nfet_01v8_lvt L=1000000
+ W=1000000 AS=250000000000 AD=300000000000 PS=1500000 PD=2600000
.ENDS NAND$1

* cell NOT
* pin
* pin
* pin
* pin sky130_gnd
* pin
.SUBCKT NOT \$1 \$2 \$8 sky130_gnd \$I5
* cell instance $1 r0 *1 1.53,1.55
X$1 \$1 vias_gen$6
* cell instance $2 r0 *1 1.045,1.28
X$2 sky130_gnd \$1 \$2 sky130_gnd nfet$2
* cell instance $3 r0 *1 2.32,1.61
X$3 \$1 vias_gen$4$1
* cell instance $4 r0 *1 1.695,4.34
X$4 \$1 vias_gen$4$1
* cell instance $5 r0 *1 0.305,3.73
X$5 \$8 \$8 \$1 \$2 \$2 \$8 pfet$1
* cell instance $6 r0 *1 1.53,4.3
X$6 \$1 vias_gen$6
* cell instance $7 r0 *1 0.18,5.29
X$7 \$8 \$I5 vias_gen$5
* cell instance $8 r0 *1 1.045,0.125
X$8 sky130_gnd vias_gen$7
.ENDS NOT

* cell NAND
* pin
* pin
* pin
* pin
* pin sky130_gnd
* pin
.SUBCKT NAND \$2 \$3 \$4 \$5 sky130_gnd \$I116
* cell instance $1 r0 *1 4.475,1.88
X$1 \$1 vias_gen$4
* cell instance $2 r0 *1 4.2,1.28
X$2 \$6 \$6 \$1 \$3 \$3 nfet
* cell instance $3 r0 *1 11.905,3.73
X$3 \$5 \$5 \$1 \$5 \$1 \$4 \$4 \$4 \$4 \$5 pfet
* cell instance $4 r0 *1 6.105,3.73
X$4 \$5 \$5 \$1 \$5 \$1 \$2 \$2 \$2 \$2 \$5 pfet
* cell instance $5 r0 *1 0.305,3.73
X$5 \$5 \$5 \$1 \$5 \$1 \$3 \$3 \$3 \$3 \$5 pfet
* cell instance $6 r0 *1 1.695,4.4
X$6 \$1 vias_gen$2
* cell instance $7 r0 *1 5.6,1.84
X$7 \$1 vias_gen$2
* cell instance $8 r0 *1 4.695,4.4
X$8 \$1 vias_gen$2
* cell instance $9 r0 *1 4.485,4.37
X$9 \$1 vias_gen$4
* cell instance $10 r0 *1 7.495,4.4
X$10 \$1 vias_gen$2
* cell instance $11 r0 *1 10.495,4.4
X$11 \$1 vias_gen$2
* cell instance $12 r0 *1 13.285,4.4
X$12 \$1 vias_gen$2
* cell instance $13 r0 *1 16.285,4.4
X$13 \$1 vias_gen$2
* cell instance $14 r0 *1 7,1.28
X$14 \$6 \$6 \$8 \$2 \$2 nfet
* cell instance $15 r0 *1 11.1,1.28
X$15 sky130_gnd sky130_gnd \$8 \$4 \$4 nfet
* cell instance $16 r0 *1 0.18,5.29
X$16 \$5 vias_gen
* cell instance $17 r0 *1 9.8,1.28
X$17 \$6 sky130_gnd sky130_gnd nfet$1
* cell instance $18 r0 *1 4.195,1.06
X$18 \$6 vias_gen$2
* cell instance $19 r0 *1 6.985,1.06
X$19 \$6 vias_gen$2
* cell instance $20 r0 *1 9.79,1.06
X$20 \$6 vias_gen$2
* cell instance $21 r0 *1 8.39,1.84
X$21 \$8 vias_gen$2
* cell instance $22 r0 *1 12.48,1.84
X$22 \$8 vias_gen$2
* cell instance $23 r0 *1 4.205,0.125
X$23 \$I116 sky130_gnd vias_gen$1
* device instance $1 r0 *1 1.105,4.23 sky130_fd_pr__pfet_01v8_lvt
XM$1 \$5 \$3 \$1 \$5 sky130_fd_pr__pfet_01v8_lvt L=1000000 W=1000000
+ AS=300000000000 AD=250000000000 PS=2600000 PD=1500000
* device instance $2 r0 *1 2.605,4.23 sky130_fd_pr__pfet_01v8_lvt
XM$2 \$1 \$3 \$5 \$5 sky130_fd_pr__pfet_01v8_lvt L=1000000 W=1000000
+ AS=250000000000 AD=250000000000 PS=1500000 PD=1500000
* device instance $3 r0 *1 4.105,4.23 sky130_fd_pr__pfet_01v8_lvt
XM$3 \$5 \$3 \$1 \$5 sky130_fd_pr__pfet_01v8_lvt L=1000000 W=1000000
+ AS=250000000000 AD=250000000000 PS=1500000 PD=1500000
* device instance $4 r0 *1 5.605,4.23 sky130_fd_pr__pfet_01v8_lvt
XM$4 \$1 \$3 \$5 \$5 sky130_fd_pr__pfet_01v8_lvt L=1000000 W=1000000
+ AS=250000000000 AD=150000000000 PS=1500000 PD=1300000
* device instance $5 r0 *1 6.905,4.23 sky130_fd_pr__pfet_01v8_lvt
XM$5 \$5 \$2 \$1 \$5 sky130_fd_pr__pfet_01v8_lvt L=1000000 W=1000000
+ AS=150000000000 AD=250000000000 PS=1300000 PD=1500000
* device instance $6 r0 *1 8.405,4.23 sky130_fd_pr__pfet_01v8_lvt
XM$6 \$1 \$2 \$5 \$5 sky130_fd_pr__pfet_01v8_lvt L=1000000 W=1000000
+ AS=250000000000 AD=250000000000 PS=1500000 PD=1500000
* device instance $7 r0 *1 9.905,4.23 sky130_fd_pr__pfet_01v8_lvt
XM$7 \$5 \$2 \$1 \$5 sky130_fd_pr__pfet_01v8_lvt L=1000000 W=1000000
+ AS=250000000000 AD=250000000000 PS=1500000 PD=1500000
* device instance $8 r0 *1 11.405,4.23 sky130_fd_pr__pfet_01v8_lvt
XM$8 \$1 \$2 \$5 \$5 sky130_fd_pr__pfet_01v8_lvt L=1000000 W=1000000
+ AS=250000000000 AD=150000000000 PS=1500000 PD=1300000
* device instance $9 r0 *1 12.705,4.23 sky130_fd_pr__pfet_01v8_lvt
XM$9 \$5 \$4 \$1 \$5 sky130_fd_pr__pfet_01v8_lvt L=1000000 W=1000000
+ AS=150000000000 AD=250000000000 PS=1300000 PD=1500000
* device instance $10 r0 *1 14.205,4.23 sky130_fd_pr__pfet_01v8_lvt
XM$10 \$1 \$4 \$5 \$5 sky130_fd_pr__pfet_01v8_lvt L=1000000 W=1000000
+ AS=250000000000 AD=250000000000 PS=1500000 PD=1500000
* device instance $11 r0 *1 15.705,4.23 sky130_fd_pr__pfet_01v8_lvt
XM$11 \$5 \$4 \$1 \$5 sky130_fd_pr__pfet_01v8_lvt L=1000000 W=1000000
+ AS=250000000000 AD=250000000000 PS=1500000 PD=1500000
* device instance $12 r0 *1 17.205,4.23 sky130_fd_pr__pfet_01v8_lvt
XM$12 \$1 \$4 \$5 \$5 sky130_fd_pr__pfet_01v8_lvt L=1000000 W=1000000
+ AS=250000000000 AD=300000000000 PS=1500000 PD=2600000
* device instance $13 r0 *1 5,1.78 sky130_fd_pr__nfet_01v8_lvt
XM$13 \$6 \$3 \$1 sky130_gnd sky130_fd_pr__nfet_01v8_lvt L=1000000 W=1000000
+ AS=300000000000 AD=250000000000 PS=2600000 PD=1500000
* device instance $14 r0 *1 6.5,1.78 sky130_fd_pr__nfet_01v8_lvt
XM$14 \$1 \$3 \$6 sky130_gnd sky130_fd_pr__nfet_01v8_lvt L=1000000 W=1000000
+ AS=250000000000 AD=150000000000 PS=1500000 PD=1300000
* device instance $15 r0 *1 7.8,1.78 sky130_fd_pr__nfet_01v8_lvt
XM$15 \$6 \$2 \$8 sky130_gnd sky130_fd_pr__nfet_01v8_lvt L=1000000 W=1000000
+ AS=150000000000 AD=250000000000 PS=1300000 PD=1500000
* device instance $16 r0 *1 9.3,1.78 sky130_fd_pr__nfet_01v8_lvt
XM$16 \$8 \$2 \$6 sky130_gnd sky130_fd_pr__nfet_01v8_lvt L=1000000 W=1000000
+ AS=250000000000 AD=150000000000 PS=1500000 PD=1300000
* device instance $17 r0 *1 10.6,1.78 sky130_fd_pr__nfet_01v8_lvt
XM$17 \$6 sky130_gnd sky130_gnd sky130_gnd sky130_fd_pr__nfet_01v8_lvt
+ L=1000000 W=1000000 AS=150000000000 AD=150000000000 PS=1300000 PD=1300000
* device instance $18 r0 *1 11.9,1.78 sky130_fd_pr__nfet_01v8_lvt
XM$18 sky130_gnd \$4 \$8 sky130_gnd sky130_fd_pr__nfet_01v8_lvt L=1000000
+ W=1000000 AS=150000000000 AD=250000000000 PS=1300000 PD=1500000
* device instance $19 r0 *1 13.4,1.78 sky130_fd_pr__nfet_01v8_lvt
XM$19 \$8 \$4 sky130_gnd sky130_gnd sky130_fd_pr__nfet_01v8_lvt L=1000000
+ W=1000000 AS=250000000000 AD=300000000000 PS=1500000 PD=2600000
.ENDS NAND

* cell vias_gen$4$2$1$1
* pin
.SUBCKT vias_gen$4$2$1$1 \$1
.ENDS vias_gen$4$2$1$1

* cell vias_gen$2$1$1$1
* pin
.SUBCKT vias_gen$2$1$1$1 \$1
.ENDS vias_gen$2$1$1$1

* cell vias_gen$1$1$1$1
* pin
* pin sky130_gnd
.SUBCKT vias_gen$1$1$1$1 \$2 sky130_gnd
.ENDS vias_gen$1$1$1$1

* cell nfet$3$1$1
* pin
* pin
* pin
* pin
* pin
.SUBCKT nfet$3$1$1 \$1 \$2 \$3 \$4 \$5
.ENDS nfet$3$1$1

* cell nfet$1$1$1$1
* pin
* pin
* pin
.SUBCKT nfet$1$1$1$1 \$1 \$2 \$3
.ENDS nfet$1$1$1$1

* cell vias_gen$8$1$1
* pin
.SUBCKT vias_gen$8$1$1 \$1
.ENDS vias_gen$8$1$1

* cell pfet$2$1$1
* pin
* pin
* pin
* pin
* pin
* pin
* pin
* pin
* pin
* pin
.SUBCKT pfet$2$1$1 \$1 \$2 \$3 \$4 \$5 \$6 \$7 \$8 \$9 \$10
.ENDS pfet$2$1$1

* cell vias_gen$4$2$1
* pin
.SUBCKT vias_gen$4$2$1 \$1
.ENDS vias_gen$4$2$1

* cell vias_gen$2$1$1
* pin
.SUBCKT vias_gen$2$1$1 \$1
.ENDS vias_gen$2$1$1

* cell vias_gen$1$1$1
* pin
* pin sky130_gnd
.SUBCKT vias_gen$1$1$1 \$2 sky130_gnd
.ENDS vias_gen$1$1$1

* cell nfet$3$1
* pin
* pin
* pin
* pin
* pin
.SUBCKT nfet$3$1 \$1 \$2 \$3 \$4 \$5
.ENDS nfet$3$1

* cell nfet$1$1$1
* pin
* pin
* pin
.SUBCKT nfet$1$1$1 \$1 \$2 \$3
.ENDS nfet$1$1$1

* cell vias_gen$8$1
* pin
* pin
.SUBCKT vias_gen$8$1 \$1 \$2
.ENDS vias_gen$8$1

* cell pfet$2$1
* pin
* pin
* pin
* pin
* pin
* pin
* pin
* pin
* pin
* pin
.SUBCKT pfet$2$1 \$1 \$2 \$3 \$4 \$5 \$6 \$7 \$8 \$9 \$10
.ENDS pfet$2$1

* cell vias_gen$6$1
* pin
.SUBCKT vias_gen$6$1 \$1
.ENDS vias_gen$6$1

* cell vias_gen$4$1$1
* pin
.SUBCKT vias_gen$4$1$1 \$1
.ENDS vias_gen$4$1$1

* cell vias_gen$7$1
* pin sky130_gnd
.SUBCKT vias_gen$7$1 sky130_gnd
.ENDS vias_gen$7$1

* cell vias_gen$5$1
* pin
* pin
.SUBCKT vias_gen$5$1 \$1 \$2
.ENDS vias_gen$5$1

* cell pfet$1$1
* pin
* pin
* pin
* pin
* pin
* pin
.SUBCKT pfet$1$1 \$1 \$2 \$3 \$4 \$5 \$6
* device instance $1 r0 *1 0.8,0.5 sky130_fd_pr__pfet_01v8_lvt
XM$1 \$1 \$4 \$3 \$6 sky130_fd_pr__pfet_01v8_lvt L=1000000 W=1000000
+ AS=300000000000 AD=250000000000 PS=2600000 PD=1500000
* device instance $2 r0 *1 2.3,0.5 sky130_fd_pr__pfet_01v8_lvt
XM$2 \$3 \$5 \$2 \$6 sky130_fd_pr__pfet_01v8_lvt L=1000000 W=1000000
+ AS=250000000000 AD=300000000000 PS=1500000 PD=2600000
.ENDS pfet$1$1

* cell nfet$2$1
* pin
* pin
* pin
* pin sky130_gnd
.SUBCKT nfet$2$1 \$1 \$2 \$3 sky130_gnd
* device instance $1 r0 *1 0.8,0.5 sky130_fd_pr__nfet_01v8_lvt
XM$1 \$1 \$3 \$2 sky130_gnd sky130_fd_pr__nfet_01v8_lvt L=1000000 W=1000000
+ AS=300000000000 AD=300000000000 PS=2600000 PD=2600000
.ENDS nfet$2$1

* cell vias_gen$4$2
* pin
.SUBCKT vias_gen$4$2 \$1
.ENDS vias_gen$4$2

* cell vias_gen$2$1
* pin
.SUBCKT vias_gen$2$1 \$1
.ENDS vias_gen$2$1

* cell vias_gen$1$1
* pin
* pin sky130_gnd
.SUBCKT vias_gen$1$1 \$2 sky130_gnd
.ENDS vias_gen$1$1

* cell nfet$3
* pin
* pin
* pin
* pin
* pin
.SUBCKT nfet$3 \$1 \$2 \$3 \$4 \$5
.ENDS nfet$3

* cell nfet$1$1
* pin
* pin
* pin
.SUBCKT nfet$1$1 \$1 \$2 \$3
.ENDS nfet$1$1

* cell vias_gen$8
* pin
* pin
.SUBCKT vias_gen$8 \$1 \$2
.ENDS vias_gen$8

* cell pfet$2
* pin
* pin
* pin
* pin
* pin
* pin
* pin
* pin
* pin
* pin
.SUBCKT pfet$2 \$1 \$2 \$3 \$4 \$5 \$6 \$7 \$8 \$9 \$10
.ENDS pfet$2

* cell vias_gen$6
* pin
.SUBCKT vias_gen$6 \$1
.ENDS vias_gen$6

* cell vias_gen$4$1
* pin
.SUBCKT vias_gen$4$1 \$1
.ENDS vias_gen$4$1

* cell vias_gen$7
* pin sky130_gnd
.SUBCKT vias_gen$7 sky130_gnd
.ENDS vias_gen$7

* cell vias_gen$5
* pin
* pin
.SUBCKT vias_gen$5 \$1 \$2
.ENDS vias_gen$5

* cell pfet$1
* pin
* pin
* pin
* pin
* pin
* pin
.SUBCKT pfet$1 \$1 \$2 \$3 \$4 \$5 \$6
* device instance $1 r0 *1 0.8,0.5 sky130_fd_pr__pfet_01v8_lvt
XM$1 \$1 \$4 \$3 \$6 sky130_fd_pr__pfet_01v8_lvt L=1000000 W=1000000
+ AS=300000000000 AD=250000000000 PS=2600000 PD=1500000
* device instance $2 r0 *1 2.3,0.5 sky130_fd_pr__pfet_01v8_lvt
XM$2 \$3 \$5 \$2 \$6 sky130_fd_pr__pfet_01v8_lvt L=1000000 W=1000000
+ AS=250000000000 AD=300000000000 PS=1500000 PD=2600000
.ENDS pfet$1

* cell nfet$2
* pin
* pin
* pin
* pin sky130_gnd
.SUBCKT nfet$2 \$1 \$2 \$3 sky130_gnd
* device instance $1 r0 *1 0.8,0.5 sky130_fd_pr__nfet_01v8_lvt
XM$1 \$1 \$3 \$2 sky130_gnd sky130_fd_pr__nfet_01v8_lvt L=1000000 W=1000000
+ AS=300000000000 AD=300000000000 PS=2600000 PD=2600000
.ENDS nfet$2

* cell vias_gen$4
* pin
.SUBCKT vias_gen$4 \$1
.ENDS vias_gen$4

* cell vias_gen$2
* pin
.SUBCKT vias_gen$2 \$1
.ENDS vias_gen$2

* cell vias_gen$1
* pin
* pin sky130_gnd
.SUBCKT vias_gen$1 \$2 sky130_gnd
.ENDS vias_gen$1

* cell nfet
* pin
* pin
* pin
* pin
* pin
.SUBCKT nfet \$1 \$2 \$3 \$4 \$5
.ENDS nfet

* cell nfet$1
* pin
* pin
* pin
.SUBCKT nfet$1 \$1 \$2 \$3
.ENDS nfet$1

* cell vias_gen
* pin
.SUBCKT vias_gen \$1
.ENDS vias_gen

* cell pfet
* pin
* pin
* pin
* pin
* pin
* pin
* pin
* pin
* pin
* pin
.SUBCKT pfet \$1 \$2 \$3 \$4 \$5 \$6 \$7 \$8 \$9 \$10
.ENDS pfet
