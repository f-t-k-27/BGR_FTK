* Extracted by KLayout with SKY130 LVS runset on : 13/10/2026 11:37

* cell NOT
* pin sky130_gnd
.SUBCKT NOT sky130_gnd
* device instance $1 r0 *1 1.605,2.35 sky130_fd_pr__pfet_01v8_lvt
XM$1 \$4 \$1 \$2 \$4 sky130_fd_pr__pfet_01v8_lvt L=1000000 W=2000000
+ AS=550000000000 AD=550000000000 PS=4100000 PD=4100000
* device instance $3 r0 *1 2.345,-0.86 sky130_fd_pr__nfet_01v8_lvt
XM$3 sky130_gnd \$1 \$2 sky130_gnd sky130_fd_pr__nfet_01v8_lvt L=1000000
+ W=1000000 AS=300000000000 AD=300000000000 PS=2600000 PD=2600000
.ENDS NOT
