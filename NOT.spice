** sch_path: /foss/designs/BGR_FTK/NOT.sch
.subckt NOT vdd vss in out
*.iopin vdd
*.iopin vss
*.ipin in
*.opin out
XM6 out in vss vss sky130_fd_pr__nfet_01v8_lvt L=1 W=1 nf=1 ad=0.29 as=0.29 pd=2.58 ps=2.58 nrd=0.29 nrs=0.29 sa=0 sb=0 sd=0
+ mult=1
XM1 out in vdd vdd sky130_fd_pr__pfet_01v8_lvt L=1 W=2 nf=2 ad=0.29 as=0.58 pd=2.58 ps=5.16 nrd=0.145 nrs=0.145 sa=0 sb=0 sd=0
+ mult=1
.ends
.end
